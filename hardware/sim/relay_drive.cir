* ZoneFlow valve-common relay driver: what happens when DRV_EN falls
* (docs/design/hardware-design.md section 7.2, review A1)
*
* K1 coil between V5 and two MOSFETs in series. Q1 is driven by expander bit
* P05 (RLY_ON) through R11, with R12 to ground. Q2 is driven by DRV_EN
* through D21 and R13, with C50 and R14 holding its gate up for 30 to 50 ms.
*
* Run:  ngspice -b relay_drive.cir
*
* DRV_EN also resets the expander, so P05 goes high impedance at the moment
* DRV_EN falls. The run shows which transistor lets go of the coil first.
* The coil inductance is not in the Omron data sheet; the run tries 50, 100
* and 300 mH. The MOSFET is a level-1 model with the AO3400A's typical
* threshold of 1.05 V and its 630 pF input capacitance as fixed capacitors.

.param lcoil=0.1
V5    v5 0 DC 4.95
LK1   v5 kx {lcoil} IC=0
RK1   kx rly_a 125
D5    rly_a v5 D4148
* DRV_EN is high from 1 ms to 100 ms.
VDRV  drv_en 0 PWL(0 0 1m 0 1.01m 3.3 100m 3.3 100.001m 0)
* Expander pin P05: drives 3.3 V while DRV_EN is high, open once it is low.
VP05  p05src 0 DC 3.3
SP05  p05src rly_on drv_en 0 SWP
.model SWP SW(VT=1.65 VH=0.1 RON=30 ROFF=1G)
R11   rly_on rly_g1 1k
R12   rly_g1 0 100k
M1    rly_a rly_g1 rly_b rly_b NFET
CGS1  rly_g1 rly_b 560p
CGD1  rly_g1 rly_a 70p
D21   drv_en rly_d D4148
R13   rly_d rly_g2 1k
R14   rly_g2 0 47k
C50   rly_g2 0 1u
M2    rly_b rly_g2 0 0 NFET
CGS2  rly_g2 0 560p
CGD2  rly_g2 rly_b 70p
BG1   vgs1 0 V = V(rly_g1) - V(rly_b)
.model NFET NMOS(LEVEL=1 VTO=1.05 KP=25 LAMBDA=0.01)
.model D4148 D(IS=2.5n N=1.75 RS=0.6 BV=100 CJO=2p TT=4n)
.options method=gear reltol=1e-4
.tran 5u 200m 0 5u uic

.control
set noaskquit
foreach l 0.05 0.1 0.3
  alterparam lcoil = $l
  reset
  run
  meas tran icoil find i(LK1) at=99m
  meas tran t_g1 when v(vgs1)=1.05 fall=last
  meas tran t_g2 when v(rly_g2)=1.05 fall=last
  meas tran t_i50 when i(LK1)=0.020 fall=last
  meas tran t_i10 when i(LK1)=0.004 fall=last
  let d_g1 = (t_g1 - 0.1)*1e3
  let d_g2 = (t_g2 - 0.1)*1e3
  let d_i50 = (t_i50 - 0.1)*1e3
  let d_i10 = (t_i10 - 0.1)*1e3
  echo "RESULT coil $l H: {$&icoil} A before DRV_EN falls; then Q1 gate under 1.05 V after {$&d_g1} ms, Q2 gate under 1.05 V after {$&d_g2} ms, coil current under 20 mA after {$&d_i50} ms and under 4 mA after {$&d_i10} ms"
end
quit
.endc
.end
